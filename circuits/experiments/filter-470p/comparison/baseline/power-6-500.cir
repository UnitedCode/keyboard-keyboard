Carrier sensor-only supply envelope; excludes Seed and all other loads
Vsource supply 0 3.3
Breg 0 rail I=max(0,min(0.5,(v(supply)-v(rail))/0.1))
Rbleed rail 0 1e9
Bhe1 rail 0 I=0.006*max(0,min(1,v(rail)/3.3))
Bhe2 rail 0 I=0.006*max(0,min(1,v(rail)/3.3))
Bhe3 rail 0 I=0.006*max(0,min(1,v(rail)/3.3))
Bhe4 rail 0 I=0.006*max(0,min(1,v(rail)/3.3))
Bhe5 rail 0 I=0.006*max(0,min(1,v(rail)/3.3))
Bhe6 rail 0 I=0.006*max(0,min(1,v(rail)/3.3))
Bhe7 rail 0 I=0.006*max(0,min(1,v(rail)/3.3))
Bhe8 rail 0 I=0.006*max(0,min(1,v(rail)/3.3))
Bhe9 rail 0 I=0.006*max(0,min(1,v(rail)/3.3))
Bhe10 rail 0 I=0.006*max(0,min(1,v(rail)/3.3))
Bhe11 rail 0 I=0.006*max(0,min(1,v(rail)/3.3))
Bhe12 rail 0 I=0.006*max(0,min(1,v(rail)/3.3))
Bhe13 rail 0 I=0.006*max(0,min(1,v(rail)/3.3))
Bhe14 rail 0 I=0.006*max(0,min(1,v(rail)/3.3))
Bhe15 rail 0 I=0.006*max(0,min(1,v(rail)/3.3))
Bhe16 rail 0 I=0.006*max(0,min(1,v(rail)/3.3))
Bhe17 rail 0 I=0.006*max(0,min(1,v(rail)/3.3))
Bhe18 rail 0 I=0.006*max(0,min(1,v(rail)/3.3))
Bhe19 rail 0 I=0.006*max(0,min(1,v(rail)/3.3))
Bhe20 rail 0 I=0.006*max(0,min(1,v(rail)/3.3))
Bhe21 rail 0 I=0.006*max(0,min(1,v(rail)/3.3))
Bhe22 rail 0 I=0.006*max(0,min(1,v(rail)/3.3))
Bhe23 rail 0 I=0.006*max(0,min(1,v(rail)/3.3))
Bhe24 rail 0 I=0.006*max(0,min(1,v(rail)/3.3))
Bhe25 rail 0 I=0.006*max(0,min(1,v(rail)/3.3))
Bhe26 rail 0 I=0.006*max(0,min(1,v(rail)/3.3))
Bhe27 rail 0 I=0.006*max(0,min(1,v(rail)/3.3))
Bhe28 rail 0 I=0.006*max(0,min(1,v(rail)/3.3))
Bhe29 rail 0 I=0.006*max(0,min(1,v(rail)/3.3))
Bhe30 rail 0 I=0.006*max(0,min(1,v(rail)/3.3))
Bhe31 rail 0 I=0.006*max(0,min(1,v(rail)/3.3))
Bhe32 rail 0 I=0.006*max(0,min(1,v(rail)/3.3))
Bhe33 rail 0 I=0.006*max(0,min(1,v(rail)/3.3))
Bhe34 rail 0 I=0.006*max(0,min(1,v(rail)/3.3))
Bhe35 rail 0 I=0.006*max(0,min(1,v(rail)/3.3))
Bhe36 rail 0 I=0.006*max(0,min(1,v(rail)/3.3))
Bhe37 rail 0 I=0.006*max(0,min(1,v(rail)/3.3))
Bhe38 rail 0 I=0.006*max(0,min(1,v(rail)/3.3))
Bhe39 rail 0 I=0.006*max(0,min(1,v(rail)/3.3))
Bhe40 rail 0 I=0.006*max(0,min(1,v(rail)/3.3))
Bhe41 rail 0 I=0.006*max(0,min(1,v(rail)/3.3))
Bhe42 rail 0 I=0.006*max(0,min(1,v(rail)/3.3))
Bhe43 rail 0 I=0.006*max(0,min(1,v(rail)/3.3))
Bhe44 rail 0 I=0.006*max(0,min(1,v(rail)/3.3))
Bhe45 rail 0 I=0.006*max(0,min(1,v(rail)/3.3))
Bhe46 rail 0 I=0.006*max(0,min(1,v(rail)/3.3))
Bhe47 rail 0 I=0.006*max(0,min(1,v(rail)/3.3))
Bhe48 rail 0 I=0.006*max(0,min(1,v(rail)/3.3))
Bhe49 rail 0 I=0.006*max(0,min(1,v(rail)/3.3))
Bhe50 rail 0 I=0.006*max(0,min(1,v(rail)/3.3))
Bhe51 rail 0 I=0.006*max(0,min(1,v(rail)/3.3))
Bhe52 rail 0 I=0.006*max(0,min(1,v(rail)/3.3))
Bhe53 rail 0 I=0.006*max(0,min(1,v(rail)/3.3))
Bhe54 rail 0 I=0.006*max(0,min(1,v(rail)/3.3))
Bhe55 rail 0 I=0.006*max(0,min(1,v(rail)/3.3))
Bhe56 rail 0 I=0.006*max(0,min(1,v(rail)/3.3))
Bhe57 rail 0 I=0.006*max(0,min(1,v(rail)/3.3))
Bhe58 rail 0 I=0.006*max(0,min(1,v(rail)/3.3))
Bhe59 rail 0 I=0.006*max(0,min(1,v(rail)/3.3))
Bhe60 rail 0 I=0.006*max(0,min(1,v(rail)/3.3))
Bhe61 rail 0 I=0.006*max(0,min(1,v(rail)/3.3))
Bhe62 rail 0 I=0.006*max(0,min(1,v(rail)/3.3))
Bhe63 rail 0 I=0.006*max(0,min(1,v(rail)/3.3))
Bhe64 rail 0 I=0.006*max(0,min(1,v(rail)/3.3))
Bhe65 rail 0 I=0.006*max(0,min(1,v(rail)/3.3))
Bhe66 rail 0 I=0.006*max(0,min(1,v(rail)/3.3))
Bhe67 rail 0 I=0.006*max(0,min(1,v(rail)/3.3))
Bhe68 rail 0 I=0.006*max(0,min(1,v(rail)/3.3))
Bhe69 rail 0 I=0.006*max(0,min(1,v(rail)/3.3))
Bhe70 rail 0 I=0.006*max(0,min(1,v(rail)/3.3))
Bhe71 rail 0 I=0.006*max(0,min(1,v(rail)/3.3))
Bhe72 rail 0 I=0.006*max(0,min(1,v(rail)/3.3))
Bhe73 rail 0 I=0.006*max(0,min(1,v(rail)/3.3))
Bhe74 rail 0 I=0.006*max(0,min(1,v(rail)/3.3))
Bhe75 rail 0 I=0.006*max(0,min(1,v(rail)/3.3))
Bhe76 rail 0 I=0.006*max(0,min(1,v(rail)/3.3))
Bhe77 rail 0 I=0.006*max(0,min(1,v(rail)/3.3))
Bhe78 rail 0 I=0.006*max(0,min(1,v(rail)/3.3))
Bhe79 rail 0 I=0.006*max(0,min(1,v(rail)/3.3))
Bhe80 rail 0 I=0.006*max(0,min(1,v(rail)/3.3))
Bhe81 rail 0 I=0.006*max(0,min(1,v(rail)/3.3))
Bhe82 rail 0 I=0.006*max(0,min(1,v(rail)/3.3))
Bhe83 rail 0 I=0.006*max(0,min(1,v(rail)/3.3))
Bhe84 rail 0 I=0.006*max(0,min(1,v(rail)/3.3))
Bhe85 rail 0 I=0.006*max(0,min(1,v(rail)/3.3))
Bhe86 rail 0 I=0.006*max(0,min(1,v(rail)/3.3))
Bhe87 rail 0 I=0.006*max(0,min(1,v(rail)/3.3))
Bhe88 rail 0 I=0.006*max(0,min(1,v(rail)/3.3))
Bhe89 rail 0 I=0.006*max(0,min(1,v(rail)/3.3))
Bhe90 rail 0 I=0.006*max(0,min(1,v(rail)/3.3))
Bhe91 rail 0 I=0.006*max(0,min(1,v(rail)/3.3))
Bhe92 rail 0 I=0.006*max(0,min(1,v(rail)/3.3))
Bhe93 rail 0 I=0.006*max(0,min(1,v(rail)/3.3))
Bhe94 rail 0 I=0.006*max(0,min(1,v(rail)/3.3))
Bhe95 rail 0 I=0.006*max(0,min(1,v(rail)/3.3))
Bhe96 rail 0 I=0.006*max(0,min(1,v(rail)/3.3))
Bhe97 rail 0 I=0.006*max(0,min(1,v(rail)/3.3))
Bhe98 rail 0 I=0.006*max(0,min(1,v(rail)/3.3))
Bhe99 rail 0 I=0.006*max(0,min(1,v(rail)/3.3))
Bhe100 rail 0 I=0.006*max(0,min(1,v(rail)/3.3))
.end
